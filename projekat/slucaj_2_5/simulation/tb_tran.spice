** sch_path: /home/Nikola.Jankovic/projekat/slucaj_2_5/testbench/tb_tran.sch
**.subckt tb_tran
Va a GND PULSE(0 1.5 0 0.1p 0.1p 100p 200p)
Vb b GND 0
Vc c GND 0
Vd d GND 1.5
Vdd net1 GND 1.5
x1 net1 out d a c b GND funkcija
**** begin user architecture code

.lib cornerMOSlv.lib mos_tt
.lib cornerMOShv.lib mos_tt
.lib cornerHBT.lib hbt_typ
.lib cornerRES.lib res_typ

.tran 0.1p 500p

.control
  save all
  run

  meas tran tr_out TRIG v(out) VAL=0.15 RISE=2 TARG v(out) VAL=1.35 RISE=2
  meas tran tf_out TRIG v(out) VAL=1.35 FALL=2 TARG v(out) VAL=0.15 FALL=2

  plot v(a)+4.5 v(b)+3 v(c)+1.5 v(out)
  wrdata /home/Nikola.Jankovic/projekat/slucaj_2_5/python/odziv_2_5.txt v(a) v(out)
  print tr_out tf_out
.endc

**** end user architecture code
**.ends

* expanding   symbol:  /home/Nikola.Jankovic/projekat/slucaj_2_5/schematic/funkcija.sym # of pins=7
** sym_path: /home/Nikola.Jankovic/projekat/slucaj_2_5/schematic/funkcija.sym
** sch_path: /home/Nikola.Jankovic/projekat/slucaj_2_5/schematic/funkcija.sch
.subckt funkcija vdd out d a c b ground
*.ipin a
*.ipin b
*.ipin c
*.ipin d
*.iopin vdd
*.iopin ground
*.opin out
XM1 net1 a ground ground sg13_lv_nmos w=0.3u l=0.13u ng=1 m=1
XM2 net1 b ground ground sg13_lv_nmos w=0.3u l=0.13u ng=1 m=1
XM3 net1 c ground ground sg13_lv_nmos w=0.3u l=0.13u ng=1 m=1
XM4 out d net1 ground sg13_lv_nmos w=0.3u l=0.13u ng=1 m=1
XM5 net2 a vdd vdd sg13_lv_pmos w=1.125u l=0.13u ng=1 m=1
XM6 net3 b net2 vdd sg13_lv_pmos w=1.125u l=0.13u ng=1 m=1
XM7 out c net3 vdd sg13_lv_pmos w=1.125u l=0.13u ng=1 m=1
XM8 out d vdd vdd sg13_lv_pmos w=0.375u l=0.13u ng=1 m=1
.ends

.GLOBAL GND
.end
