** sch_path: /home/Nikola.Jankovic/projekat/slucaj_2/testbench/tb_dc_current.sch
**.subckt tb_dc_current
Va a GND PULSE(0 1.5 0 100p 100p 200p 500p)
Vb b GND 0
Vc c GND 0
Vd d GND 1.5
Vdd net1 GND 1.5
x1 net1 out d a c b GND funkcija
**** begin user architecture code

.lib cornerMOSlv.lib mos_tt
.lib cornerMOShv.lib mos_tt
.lib cornerHBT.lib hbt_typ
.lib cornerRES.lib res_typ

* DC sweep ulaznog napona Va od 0 do 1.5V sa korakom 0.01V

.dc Va 0 1.5 0.01

.control
  run

  wrdata /home/Nikola.Jankovic/projekat/slucaj_2/python/struja.txt v(a) i(Vdd)

  plot -i(Vdd)
.endc

**** end user architecture code
**.ends

* expanding   symbol:  /home/Nikola.Jankovic/projekat/slucaj_2/schematic/funkcija.sym # of pins=7
** sym_path: /home/Nikola.Jankovic/projekat/slucaj_2/schematic/funkcija.sym
** sch_path: /home/Nikola.Jankovic/projekat/slucaj_2/schematic/funkcija.sch
.subckt funkcija vdd out d a c b GND
*.ipin a
*.ipin b
*.ipin c
*.ipin d
*.iopin vdd
*.iopin GND
*.opin out
XM1 net1 a GND GND sg13_lv_nmos w=0.3u l=0.13u ng=1 m=1
XM2 net1 b GND GND sg13_lv_nmos w=0.3u l=0.13u ng=1 m=1
XM3 net1 c GND GND sg13_lv_nmos w=0.3u l=0.13u ng=1 m=1
XM4 out d net1 GND sg13_lv_nmos w=0.3u l=0.13u ng=1 m=1
XM5 net2 a vdd vdd sg13_lv_pmos w=0.9u l=0.13u ng=1 m=1
XM6 net3 b net2 vdd sg13_lv_pmos w=0.9u l=0.13u ng=1 m=1
XM7 out c net3 vdd sg13_lv_pmos w=0.9u l=0.13u ng=1 m=1
XM8 out d vdd vdd sg13_lv_pmos w=0.3u l=0.13u ng=1 m=1
.ends

.GLOBAL GND
.end
