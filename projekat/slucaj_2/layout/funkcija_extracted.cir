* Extracted by KLayout with SG13G2 LVS runset on : 08/05/2026 14:27

.SUBCKT funkcija
M$1 \$1 \$7 \$3 \$1 sg13_lv_nmos L=0.13u W=0.3u AS=0.102p AD=0.057p PS=1.28u
+ PD=0.68u
M$2 \$3 \$6 \$1 \$1 sg13_lv_nmos L=0.13u W=0.3u AS=0.057p AD=0.057p PS=0.68u
+ PD=0.68u
M$3 \$1 \$5 \$3 \$1 sg13_lv_nmos L=0.13u W=0.3u AS=0.057p AD=0.057p PS=0.68u
+ PD=0.68u
M$4 \$3 \$4 \$10 \$1 sg13_lv_nmos L=0.13u W=0.3u AS=0.057p AD=0.102p PS=0.68u
+ PD=1.28u
M$5 \$10 \$4 \$2 \$2 sg13_lv_pmos L=0.13u W=0.3u AS=0.102p AD=0.102p PS=1.28u
+ PD=1.28u
M$6 \$2 \$7 \$8 \$2 sg13_lv_pmos L=0.13u W=0.9u AS=0.306p AD=0.171p PS=2.48u
+ PD=1.28u
M$7 \$8 \$6 \$9 \$2 sg13_lv_pmos L=0.13u W=0.9u AS=0.171p AD=0.171p PS=1.28u
+ PD=1.28u
M$8 \$9 \$5 \$10 \$2 sg13_lv_pmos L=0.13u W=0.9u AS=0.171p AD=0.306p PS=1.28u
+ PD=2.48u
.ENDS funkcija
