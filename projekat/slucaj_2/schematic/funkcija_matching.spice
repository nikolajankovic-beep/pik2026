** sch_path: /home/Nikola.Jankovic/projekat_copy/slucaj_2/schematic/funkcija_matching.sch
.subckt funkcija_matching vdd out d a c b ground
*.PININFO a:I b:I c:I d:I vdd:B ground:B out:O
M1 net1 a ground ground sg13_lv_nmos w=0.3u l=0.13u ng=1 m=1
M2 net1 b ground ground sg13_lv_nmos w=0.3u l=0.13u ng=1 m=1
M3 net1 c ground ground sg13_lv_nmos w=0.3u l=0.13u ng=1 m=1
M4 out d net1 ground sg13_lv_nmos w=0.3u l=0.13u ng=1 m=1
M5 net2 a vdd vdd sg13_lv_pmos w=0.9u l=0.13u ng=1 m=1
M6 net3 b net2 vdd sg13_lv_pmos w=0.9u l=0.13u ng=1 m=1
M7 out c net3 vdd sg13_lv_pmos w=0.9u l=0.13u ng=1 m=1
M8 out d vdd vdd sg13_lv_pmos w=0.3u l=0.13u ng=1 m=1
M9 ground ground ground ground sg13_lv_nmos w=0.3u l=0.13u ng=1 m=1
M10 out ground out ground sg13_lv_nmos w=0.3u l=0.13u ng=1 m=1
M11 vdd vdd vdd vdd sg13_lv_pmos w=0.3u l=0.13u ng=1 m=1
M12 vdd vdd vdd vdd sg13_lv_pmos w=0.3u l=0.13u ng=1 m=1
.ends
.end
