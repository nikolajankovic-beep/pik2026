** sch_path: /home/Nikola.Jankovic/projekat/slucaj_3/tb_tran.sch
**.subckt tb_tran
Va a GND 1.5
Vb b GND 1.5
Vc c GND 1.5
Vd d GND PULSE(0 1.5 0 0.1p 0.1p 100p 200p)
Vdd net1 GND 1.5
x1 net1 out d a c b GND sema
**** begin user architecture code

.lib cornerMOSlv.lib mos_tt
.lib cornerMOShv.lib mos_tt
.lib cornerHBT.lib hbt_typ
.lib cornerRES.lib res_typ

.tran 0.1p 500p

.control
  save all
  run

  meas tran tr_out TRIG v(out) VAL=0.15 RISE=2 TARG v(out) VAL=1.35 RISE=2
  meas tran tf_out TRIG v(out) VAL=1.35 FALL=2 TARG v(out) VAL=0.15 FALL=2

  plot v(a)+6 v(b)+4.5 v(c)+3 v(d)+1.5 v(out)
  print tr_out tf_out
.endc

**** end user architecture code
**.ends

* expanding   symbol:  /home/Nikola.Jankovic/projekat/slucaj_3/sema.sym # of pins=7
** sym_path: /home/Nikola.Jankovic/projekat/slucaj_3/sema.sym
** sch_path: /home/Nikola.Jankovic/projekat/slucaj_3/sema.sch
.subckt sema vdd out d a c b ground
*.ipin a
*.ipin b
*.ipin c
*.ipin d
*.iopin vdd
*.iopin ground
*.opin out
XM1 net1 a ground ground sg13_lv_nmos w=0.3u l=0.13u ng=1 m=1
XM2 net1 b ground ground sg13_lv_nmos w=0.3u l=0.13u ng=1 m=1
XM3 net1 c ground ground sg13_lv_nmos w=0.3u l=0.13u ng=1 m=1
XM4 out d net1 ground sg13_lv_nmos w=0.3u l=0.13u ng=1 m=1
XM5 net2 a vdd vdd sg13_lv_pmos w=1.35u l=0.13u ng=1 m=1
XM6 net3 b net2 vdd sg13_lv_pmos w=1.35u l=0.13u ng=1 m=1
XM7 out c net3 vdd sg13_lv_pmos w=1.35u l=0.13u ng=1 m=1
XM8 out d vdd vdd sg13_lv_pmos w=0.45u l=0.13u ng=1 m=1
.ends

.GLOBAL GND
.end
